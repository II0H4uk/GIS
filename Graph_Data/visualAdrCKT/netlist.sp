.SUBCKT PADIN_Adress nClk gnd! vdd! A nATD Adr
** N=24 EP=6 IP=164 FDC=120
M0 nATD 17 gnd! gnd! nmos_a L=2.4e-07 W=3.6e-06 AD=1.664e-12 AS=1.44e-12 PD=4.16e-06 PS=2.08e-06 w_cont=1.6e-06 nfing=1 source_num=2 $X=15140 $Y=324580 $D=1
M1 Adr 13 gnd! gnd! nmos_a L=2.4e-07 W=7.2e-06 AD=1.648e-12 AS=2.88e-12 PD=4.12e-06 PS=2.06e-06 w_cont=3.1e-06 nfing=1 source_num=2 $X=60100 $Y=319220 $D=1
M2 Adr 13 gnd! gnd! nmos_a L=2.4e-07 W=7.2e-06 AD=1.648e-12 AS=2.88e-12 PD=4.12e-06 PS=2.06e-06 w_cont=3.1e-06 nfing=1 source_num=2 $X=64840 $Y=319220 $D=1
M3 Adr 13 gnd! gnd! nmos_a L=2.4e-07 W=7.2e-06 AD=1.648e-12 AS=2.88e-12 PD=4.12e-06 PS=2.06e-06 w_cont=3.1e-06 nfing=1 source_num=2 $X=69740 $Y=319220 $D=1
M4 Adr 13 gnd! gnd! nmos_a L=2.4e-07 W=7.2e-06 AD=1.648e-12 AS=2.88e-12 PD=4.12e-06 PS=2.06e-06 w_cont=3.1e-06 nfing=1 source_num=2 $X=74480 $Y=319220 $D=1
M5 Adr 13 gnd! gnd! nmos_a L=2.4e-07 W=7.2e-06 AD=1.648e-12 AS=2.88e-12 PD=4.12e-06 PS=2.06e-06 w_cont=3.1e-06 nfing=1 source_num=2 $X=79380 $Y=319220 $D=1
M6 Adr 13 gnd! gnd! nmos_a L=2.4e-07 W=7.2e-06 AD=1.648e-12 AS=2.88e-12 PD=4.12e-06 PS=2.06e-06 w_cont=3.1e-06 nfing=1 source_num=2 $X=84120 $Y=319220 $D=1
M7 Adr 13 gnd! gnd! nmos_a L=2.4e-07 W=7.2e-06 AD=1.648e-12 AS=2.88e-12 PD=4.12e-06 PS=2.06e-06 w_cont=3.1e-06 nfing=1 source_num=2 $X=89020 $Y=319220 $D=1
M8 Adr 13 gnd! gnd! nmos_a L=2.4e-07 W=7.2e-06 AD=1.648e-12 AS=2.88e-12 PD=4.12e-06 PS=2.06e-06 w_cont=3.1e-06 nfing=1 source_num=2 $X=93760 $Y=319220 $D=1
M9 20 8 gnd! gnd! nmos_a L=2.4e-07 W=2.4e-06 AD=1.4e-12 AS=9.6e-13 PD=3.5e-06 PS=1.75e-06 w_cont=1.1e-06 nfing=1 source_num=2 $X=33840 $Y=326820 $D=1
M10 12 10 20 20 nmos_a L=2.4e-07 W=2.4e-06 AD=1.4e-12 AS=9.6e-13 PD=3.5e-06 PS=1.75e-06 w_cont=1.1e-06 nfing=1 source_num=2 $X=35280 $Y=326540 $D=1
M11 8 24 gnd! gnd! nmos_a L=2.4e-07 W=1.2e-06 AD=7.2e-13 AS=4.8e-13 PD=1.8e-06 PS=9e-07 w_cont=6e-07 nfing=1 source_num=2 $X=9380 $Y=325780 $D=1
M12 15 9 gnd! gnd! nmos_a L=2.4e-07 W=1.2e-06 AD=7.2e-13 AS=4.8e-13 PD=1.8e-06 PS=9e-07 w_cont=6e-07 nfing=1 source_num=2 $X=10820 $Y=325780 $D=1
M13 17 8 15 15 nmos_a L=2.4e-07 W=1.2e-06 AD=4.68e-13 AS=4.8e-13 PD=9e-07 PS=9e-07 w_cont=6e-07 nfing=1 source_num=2 $X=12320 $Y=328520 $D=1
M14 17 7 19 19 nmos_a L=2.4e-07 W=1.2e-06 AD=4.68e-13 AS=4.8e-13 PD=9e-07 PS=9e-07 w_cont=6e-07 nfing=1 source_num=2 $X=13080 $Y=328520 $D=1
M15 19 12 gnd! gnd! nmos_a L=2.4e-07 W=1.2e-06 AD=7.2e-13 AS=4.8e-13 PD=1.8e-06 PS=9e-07 w_cont=6e-07 nfing=1 source_num=2 $X=13700 $Y=325780 $D=1
M16 9 12 gnd! gnd! nmos_a L=2.4e-07 W=1.2e-06 AD=7.2e-13 AS=6.24e-13 PD=1.8e-06 PS=9e-07 w_cont=6e-07 nfing=1 source_num=2 $X=36680 $Y=327740 $D=1
M17 22 9 gnd! gnd! nmos_a L=2.4e-07 W=1.2e-06 AD=7.2e-13 AS=6.24e-13 PD=1.8e-06 PS=9e-07 w_cont=6e-07 nfing=1 source_num=2 $X=37440 $Y=327740 $D=1
M18 12 11 22 22 nmos_a L=2.4e-07 W=1.2e-06 AD=7.2e-13 AS=4.8e-13 PD=1.8e-06 PS=9e-07 w_cont=6e-07 nfing=1 source_num=2 $X=38880 $Y=327420 $D=1
M19 10 11 gnd! gnd! nmos_a L=2.4e-07 W=1.2e-06 AD=7.2e-13 AS=4.8e-13 PD=1.8e-06 PS=9e-07 w_cont=6e-07 nfing=1 source_num=2 $X=40280 $Y=327420 $D=1
M20 11 nClk gnd! gnd! nmos_a L=2.4e-07 W=1.2e-06 AD=7.2e-13 AS=4.8e-13 PD=1.8e-06 PS=9e-07 w_cont=6e-07 nfing=1 source_num=2 $X=41720 $Y=327420 $D=1
M21 7 8 gnd! gnd! nmos_a L=2.4e-07 W=4.8e-07 AD=4.32e-13 AS=1.92e-13 PD=1.08e-06 PS=5.4e-07 w_cont=6e-07 nfing=1 source_num=2 $X=12260 $Y=325980 $D=1
M22 13 12 gnd! gnd! nmos_a L=2.4e-07 W=3.6e-06 AD=1.664e-12 AS=1.44e-12 PD=4.16e-06 PS=2.08e-06 w_cont=1.6e-06 nfing=1 source_num=2 $X=47800 $Y=327560 $D=1
M23 13 12 gnd! gnd! nmos_a L=2.4e-07 W=3.6e-06 AD=1.664e-12 AS=1.44e-12 PD=4.16e-06 PS=2.08e-06 w_cont=1.6e-06 nfing=1 source_num=2 $X=53880 $Y=327560 $D=1
M24 18 9 vdd! vdd! pmos_a L=2.4e-07 W=2e-06 AD=1.04e-12 AS=1.3e-13 PD=2.6e-06 PS=1.3e-06 w_cont=6e-07 nfing=1 mmm=1 $X=13640 $Y=334500 $D=5
M25 nATD 17 vdd! vdd! pmos_a L=2.4e-07 W=5.76e-06 AD=2.744e-12 AS=2.488e-13 PD=6.86e-06 PS=3.43e-06 w_cont=1.1e-06 nfing=1 mmm=1 $X=15140 $Y=330600 $D=5
M26 Adr 13 vdd! vdd! pmos_a L=2.4e-07 W=1.1e-05 AD=2.63913e-12 AS=1.96364e-13 PD=6.59782e-06 PS=3.29891e-06 w_cont=1.6e-06 nfing=1 mmm=1 $X=60100 $Y=330700 $D=5
M27 Adr 13 vdd! vdd! pmos_a L=2.4e-07 W=1.1e-05 AD=2.63913e-12 AS=1.96364e-13 PD=6.59782e-06 PS=3.29891e-06 w_cont=1.6e-06 nfing=1 mmm=1 $X=64840 $Y=330700 $D=5
M28 Adr 13 vdd! vdd! pmos_a L=2.4e-07 W=1.1e-05 AD=2.63913e-12 AS=1.96364e-13 PD=6.59782e-06 PS=3.29891e-06 w_cont=1.6e-06 nfing=1 mmm=1 $X=69740 $Y=330700 $D=5
M29 Adr 13 vdd! vdd! pmos_a L=2.4e-07 W=1.088e-05 AD=2.64282e-12 AS=1.98212e-13 PD=6.60706e-06 PS=3.30353e-06 w_cont=1.6e-06 nfing=1 mmm=1 $X=74480 $Y=330820 $D=5
M30 Adr 13 vdd! vdd! pmos_a L=2.4e-07 W=1.1e-05 AD=2.63913e-12 AS=1.96364e-13 PD=6.59782e-06 PS=3.29891e-06 w_cont=1.6e-06 nfing=1 mmm=1 $X=79380 $Y=330700 $D=5
M31 Adr 13 vdd! vdd! pmos_a L=2.4e-07 W=1.1e-05 AD=2.63913e-12 AS=1.96364e-13 PD=6.59782e-06 PS=3.29891e-06 w_cont=1.6e-06 nfing=1 mmm=1 $X=84120 $Y=330700 $D=5
M32 Adr 13 vdd! vdd! pmos_a L=2.4e-07 W=1.1e-05 AD=2.63913e-12 AS=1.96364e-13 PD=6.59782e-06 PS=3.29891e-06 w_cont=1.6e-06 nfing=1 mmm=1 $X=89020 $Y=330700 $D=5
M33 Adr 13 vdd! vdd! pmos_a L=2.4e-07 W=1.1e-05 AD=2.63913e-12 AS=1.96364e-13 PD=6.59782e-06 PS=3.29891e-06 w_cont=1.6e-06 nfing=1 mmm=1 $X=93760 $Y=330700 $D=5
M34 13 12 vdd! vdd! pmos_a L=2.4e-07 W=5.76e-06 AD=2.744e-12 AS=2.488e-13 PD=6.86e-06 PS=3.43e-06 w_cont=1.1e-06 nfing=1 mmm=1 $X=46400 $Y=327560 $D=5
M35 13 12 vdd! vdd! pmos_a L=2.4e-07 W=5.76e-06 AD=2.744e-12 AS=2.488e-13 PD=6.86e-06 PS=3.43e-06 w_cont=1.1e-06 nfing=1 mmm=1 $X=52480 $Y=327560 $D=5
M36 14 14 vdd! vdd! pmos_a L=2.4e-07 W=2e-06 AD=6.76e-13 AS=1.3e-13 PD=1.3e-06 PS=1.3e-06 w_cont=6e-07 nfing=1 mmm=1 $X=9240 $Y=334300 $D=5
M37 14 14 vdd! vdd! pmos_a L=2.4e-07 W=2e-06 AD=6.76e-13 AS=1.66e-13 PD=1.3e-06 PS=1.3e-06 w_cont=6e-07 nfing=1 mmm=1 $X=10000 $Y=334300 $D=5
M38 16 12 vdd! vdd! pmos_a L=2.4e-07 W=2e-06 AD=1.04e-12 AS=1.66e-13 PD=2.6e-06 PS=1.3e-06 w_cont=6e-07 nfing=1 mmm=1 $X=10760 $Y=334300 $D=5
M39 17 8 16 16 pmos_a L=2.4e-07 W=2e-06 AD=6.76e-13 AS=1.3e-13 PD=1.3e-06 PS=1.3e-06 w_cont=6e-07 nfing=1 mmm=1 $X=12320 $Y=331000 $D=5
M40 17 7 18 18 pmos_a L=2.4e-07 W=2e-06 AD=6.76e-13 AS=1.3e-13 PD=1.3e-06 PS=1.3e-06 w_cont=6e-07 nfing=1 mmm=1 $X=13080 $Y=331000 $D=5
M41 9 12 vdd! vdd! pmos_a L=2.4e-07 W=2e-06 AD=1.04e-12 AS=1.66e-13 PD=2.6e-06 PS=1.3e-06 w_cont=6e-07 nfing=1 mmm=1 $X=36680 $Y=330700 $D=5
M42 23 9 vdd! vdd! pmos_a L=2.4e-07 W=2e-06 AD=1.04e-12 AS=1.66e-13 PD=2.6e-06 PS=1.3e-06 w_cont=6e-07 nfing=1 mmm=1 $X=37440 $Y=330700 $D=5
M43 12 10 23 23 pmos_a L=2.4e-07 W=2e-06 AD=1.04e-12 AS=1.3e-13 PD=2.6e-06 PS=1.3e-06 w_cont=6e-07 nfing=1 mmm=1 $X=38880 $Y=330200 $D=5
M44 10 11 vdd! vdd! pmos_a L=2.4e-07 W=2e-06 AD=1.04e-12 AS=1.3e-13 PD=2.6e-06 PS=1.3e-06 w_cont=6e-07 nfing=1 mmm=1 $X=40280 $Y=330200 $D=5
M45 11 nClk vdd! vdd! pmos_a L=2.4e-07 W=2e-06 AD=1.04e-12 AS=1.3e-13 PD=2.6e-06 PS=1.3e-06 w_cont=6e-07 nfing=1 mmm=1 $X=41720 $Y=331700 $D=5
M46 7 8 vdd! vdd! pmos_a L=2.4e-07 W=1e-06 AD=6.4e-13 AS=1.25e-13 PD=1.6e-06 PS=8e-07 w_cont=6e-07 nfing=1 mmm=1 $X=12200 $Y=335000 $D=5
M47 14 7 vdd! vdd! pmos_a L=2.4e-07 W=4e-06 AD=1.84e-12 AS=1.4e-13 PD=4.6e-06 PS=2.3e-06 w_cont=6e-07 nfing=1 mmm=1 $X=8800 $Y=329000 $D=5
M48 8 24 14 14 pmos_a L=2.4e-07 W=4e-06 AD=1.84e-12 AS=1.4e-13 PD=4.6e-06 PS=2.3e-06 w_cont=6e-07 nfing=1 mmm=1 $X=10240 $Y=328320 $D=5
M49 21 8 vdd! vdd! pmos_a L=2.4e-07 W=4e-06 AD=1.84e-12 AS=1.4e-13 PD=4.6e-06 PS=2.3e-06 w_cont=6e-07 nfing=1 mmm=1 $X=33840 $Y=331020 $D=5
M50 12 11 21 21 pmos_a L=2.4e-07 W=4e-06 AD=1.84e-12 AS=1.4e-13 PD=4.6e-06 PS=2.3e-06 w_cont=6e-07 nfing=1 mmm=1 $X=35280 $Y=331020 $D=5
M51 vdd! gnd! vdd! cpoly_n w=6e-06 l=2e-06 c=7.5402e-14 as=2.4e-13 ad=2.304e-12 ps=2.88e-06 pd=4.86761e-06 sim_w=5.76e-06 m_per_maxw=1.04167 numb_sub_cont=3 nfing=1 $X=30600 $Y=328520 $D=22
M52 vdd! gnd! vdd! cpoly_n w=6e-06 l=2e-06 c=7.5402e-14 as=2.4e-13 ad=2.304e-12 ps=2.88e-06 pd=4.86761e-06 sim_w=5.76e-06 m_per_maxw=1.04167 numb_sub_cont=3 nfing=1 $X=43200 $Y=328200 $D=22
M53 vdd! gnd! vdd! cpoly_n w=6e-06 l=2e-06 c=7.5402e-14 as=2.4e-13 ad=2.304e-12 ps=2.88e-06 pd=4.86761e-06 sim_w=5.76e-06 m_per_maxw=1.04167 numb_sub_cont=3 nfing=1 $X=49280 $Y=328200 $D=22
M54 vdd! gnd! vdd! cpoly_n w=6e-06 l=2e-06 c=7.5402e-14 as=2.4e-13 ad=2.304e-12 ps=2.88e-06 pd=4.86761e-06 sim_w=5.76e-06 m_per_maxw=1.04167 numb_sub_cont=3 nfing=1 $X=55360 $Y=328200 $D=22
M55 vdd! gnd! vdd! cpoly_n w=6e-06 l=2e-06 c=7.5402e-14 as=2.4e-13 ad=2.304e-12 ps=2.88e-06 pd=4.86761e-06 sim_w=5.76e-06 m_per_maxw=1.04167 numb_sub_cont=3 nfing=1 $X=61600 $Y=328200 $D=22
M56 vdd! gnd! vdd! cpoly_n w=6e-06 l=2e-06 c=7.5402e-14 as=2.4e-13 ad=2.304e-12 ps=2.88e-06 pd=4.86761e-06 sim_w=5.76e-06 m_per_maxw=1.04167 numb_sub_cont=3 nfing=1 $X=61600 $Y=336700 $D=22
M57 vdd! gnd! vdd! cpoly_n w=6e-06 l=2e-06 c=7.5402e-14 as=2.4e-13 ad=2.304e-12 ps=2.88e-06 pd=4.86761e-06 sim_w=5.76e-06 m_per_maxw=1.04167 numb_sub_cont=3 nfing=1 $X=66480 $Y=336700 $D=22
M58 vdd! gnd! vdd! cpoly_n w=6e-06 l=2e-06 c=7.5402e-14 as=2.4e-13 ad=2.304e-12 ps=2.88e-06 pd=4.86761e-06 sim_w=5.76e-06 m_per_maxw=1.04167 numb_sub_cont=3 nfing=1 $X=71240 $Y=328200 $D=22
M59 vdd! gnd! vdd! cpoly_n w=6e-06 l=2e-06 c=7.5402e-14 as=2.4e-13 ad=2.304e-12 ps=2.88e-06 pd=4.86761e-06 sim_w=5.76e-06 m_per_maxw=1.04167 numb_sub_cont=3 nfing=1 $X=71240 $Y=336700 $D=22
M60 vdd! gnd! vdd! cpoly_n w=6e-06 l=2e-06 c=7.5402e-14 as=2.4e-13 ad=2.304e-12 ps=2.88e-06 pd=4.86761e-06 sim_w=5.76e-06 m_per_maxw=1.04167 numb_sub_cont=3 nfing=1 $X=76120 $Y=336700 $D=22
M61 vdd! gnd! vdd! cpoly_n w=6e-06 l=2e-06 c=7.5402e-14 as=2.4e-13 ad=2.304e-12 ps=2.88e-06 pd=4.86761e-06 sim_w=5.76e-06 m_per_maxw=1.04167 numb_sub_cont=3 nfing=1 $X=80880 $Y=328200 $D=22
M62 vdd! gnd! vdd! cpoly_n w=6e-06 l=2e-06 c=7.5402e-14 as=2.4e-13 ad=2.304e-12 ps=2.88e-06 pd=4.86761e-06 sim_w=5.76e-06 m_per_maxw=1.04167 numb_sub_cont=3 nfing=1 $X=80880 $Y=336700 $D=22
M63 vdd! gnd! vdd! cpoly_n w=6e-06 l=2e-06 c=7.5402e-14 as=2.4e-13 ad=2.304e-12 ps=2.88e-06 pd=4.86761e-06 sim_w=5.76e-06 m_per_maxw=1.04167 numb_sub_cont=3 nfing=1 $X=85760 $Y=336700 $D=22
M64 vdd! gnd! vdd! cpoly_n w=6e-06 l=2e-06 c=7.5402e-14 as=2.4e-13 ad=2.304e-12 ps=2.88e-06 pd=4.86761e-06 sim_w=5.76e-06 m_per_maxw=1.04167 numb_sub_cont=3 nfing=1 $X=90520 $Y=328200 $D=22
M65 vdd! gnd! vdd! cpoly_n w=6e-06 l=2e-06 c=7.5402e-14 as=2.4e-13 ad=2.304e-12 ps=2.88e-06 pd=4.86761e-06 sim_w=5.76e-06 m_per_maxw=1.04167 numb_sub_cont=3 nfing=1 $X=90520 $Y=336700 $D=22
M66 vdd! gnd! vdd! cpoly_n w=6e-06 l=2e-06 c=7.5402e-14 as=2.4e-13 ad=2.304e-12 ps=2.88e-06 pd=4.86761e-06 sim_w=5.76e-06 m_per_maxw=1.04167 numb_sub_cont=3 nfing=1 $X=95400 $Y=336700 $D=22
D67 gnd! 24 dn PJ=5e-06 m=1 $X=1560 $Y=328560 $D=10
D68 24 vdd! dn PJ=5e-06 m=1 $X=1560 $Y=334960 $D=10
D69 gnd! 24 dn PJ=5e-06 m=1 $X=1560 $Y=329900 $D=11
D70 24 vdd! dn PJ=5e-06 m=1 $X=1560 $Y=332220 $D=11
.ENDS
***************************************
