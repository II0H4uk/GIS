* SPICE NETLIST
***************************************

.SUBCKT pmos_h
** N=4 EP=0 IP=0 FDC=0
.ENDS
***************************************
.SUBCKT circuit 1 0 2
** N=4 EP=4 IP=32 FDC=8
D0 10 11 pmos_h L=3.5e-07 W=1e-06 $X=6950 $Y=1600 $D=3
D1 9 10 pmos_h L=3.5e-07 W=1e-06 $X=6950 $Y=4850 $D=3
D2 5 7 pmos_h L=3.5e-07 W=1e-06 $X=6950 $Y=8100 $D=3
D3 4 6 pmos_h L=3.5e-07 W=1e-06 $X=6950 $Y=11350 $D=3
D4 3 4 pmos_h L=3.5e-07 W=1e-06 $X=6950 $Y=11350 $D=3
D5 0 3 pmos_h L=3.5e-07 W=1e-06 $X=6950 $Y=11350 $D=3
D6 1 5 pmos_h L=3.5e-07 W=1e-06 $X=6950 $Y=11350 $D=3
D7 2 5 pmos_h L=3.5e-07 W=1e-06 $X=6950 $Y=11350 $D=3
M0 6 7 8 pmos_h L=3.5e-07 W=1e-06 $X=11200 $Y=4850 $D=3
M1 5 6 7 pmos_h L=3.5e-07 W=1e-06 $X=11200 $Y=8100 $D=3
M2 6 7 9 pmos_h L=3.5e-07 W=1e-06 $X=11200 $Y=11350 $D=3
.ENDS
***************************************
