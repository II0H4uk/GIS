* SPICE NETLIST
***************************************

.SUBCKT pmos_h
** N=4 EP=0 IP=0 FDC=0
.ENDS
***************************************
.SUBCKT circuit 0 1
** N=4 EP=4 IP=32 FDC=8
D0 0 2 pmos_h L=3.5e-07 W=1e-06 $X=6950 $Y=1600 $D=3
D1 2 5 pmos_h L=3.5e-07 W=1e-06 $X=6950 $Y=4850 $D=3
D2 1 2 pmos_h L=3.5e-07 W=1e-06 $X=6950 $Y=8100 $D=3
D3 1 3 pmos_h L=3.5e-07 W=1e-06 $X=6950 $Y=11350 $D=3
D4 8 9 pmos_h L=3.5e-07 W=1e-06 $X=6950 $Y=11350 $D=3
D5 2 8 pmos_h L=3.5e-07 W=1e-06 $X=6950 $Y=11350 $D=3
T0 2 5 6 pmos_h L=3.5e-07 W=1e-06 $X=11200 $Y=4850 $D=3
T1 2 3 4 pmos_h L=3.5e-07 W=1e-06 $X=11200 $Y=8100 $D=3
T2 4 6 7 pmos_h L=3.5e-07 W=1e-06 $X=11200 $Y=11350 $D=3
T3 0 1 2 pmos_h L=3.5e-07 W=1e-06 $X=11200 $Y=1600 $D=3
.ENDS
***************************************
